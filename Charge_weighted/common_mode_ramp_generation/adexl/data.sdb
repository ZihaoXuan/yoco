ADE simulation setup
Run mode: Single Run, Sweeps and Corners
Tests:
  Charge_weighted:common_mode_ramp_generation:1: Charge_weighted/common_mode_ramp_generation/schematic, simulator spectre
    Outputs: /TP; /TN; /net012
Global variables:
  vdc = {From/To}Auto:0:33:512m{From/To}
Corners (all switched off):
  model folders: /netstorage/soft2/technology/SMIC28HKCP/pdk/SPDK28HKCPlusLG_0918_OA_CDS_V1.0_REV3_0/smic28hkcPluslg_0918_1P8M_6Ic_2TMc_ALPA2_oa_cds_2018_12_05_v1.0_rev3_0/smic28hkmg/../models/spectre
  C0: temperature=25; vdc={From/To}Auto:0:9:512m{From/To}; l0028hkcplus_io18_v1p0_rev3_spe.lib[mos_mc, mom_mc, var_mc, bjt_mc, res_mc]
