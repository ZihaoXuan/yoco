ADE simulation setup
Run mode: Monte Carlo Sampling
Tests:
  Charge_weighted:LCC_SUB256_TB:1: Charge_weighted/LCC_SUB256_TB/schematic, simulator spectre
    Outputs: /I15/I26<127>/net7
Global variables (all switched off):
  a = {Inclusion List}0 0.9{Inclusion List}
  b = {Inclusion List}0 0.9{Inclusion List}
  c = {Inclusion List}0 0.9{Inclusion List}
  d = {Inclusion List}0 0.9{Inclusion List}
  e = {Inclusion List}0 0.9{Inclusion List}
  f = {Inclusion List}0 0.9{Inclusion List}
  g = {Inclusion List}0 0.9{Inclusion List}
  h = {Inclusion List}0 0.9{Inclusion List}
Corners (nominal off):
  every corner: /netstorage/soft2/technology/SMIC28HKCP/pdk/SPDK28HKCPlusLG_0918_OA_CDS_V1.0_REV3_0/smic28hkcPluslg_0918_1P8M_6Ic_2TMc_ALPA2_oa_cds_2018_12_05_v1.0_rev3_0/smic28hkmg/../models/spectre/l0028hkcplus_io18_v1p0_rev3_spe.lib[tt, bjt_mc, dio_tt, res_mc, var_mc, mom_mc, ldmos_mc, esd_tt, esd_dio_tt]
  C1 (off): temperature=25; a=0.9; b=0; c=0; d=0; e=0; f=0; g=0; h=0
  C2 (off): temperature=25; a=0; b=0; c=0; d=0; e=0; f=0; g=0; h=0
  C3: temperature=25; a=0.9; b=0.9; c=0.9; d=0.9; e=0.9; f=0.9; g=0.9; h=0.9
Monte Carlo Sampling options: mcmethod=all, mcnumpoints=2000
