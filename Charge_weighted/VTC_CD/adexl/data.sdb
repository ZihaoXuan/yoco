ADE simulation setup
Run mode: Monte Carlo Sampling
Tests:
  Charge_weighted:VTC_CD:1: Charge_weighted/VTC_CD/schematic, simulator spectre
    Outputs: /SP
Global variables:
  vdc = {From/To}Auto:0.9:17:0.388{From/To} (off)
Corners:
  model folders: /netstorage/soft2/technology/SMIC28HKCP/pdk/SPDK28HKCPlusLG_0918_OA_CDS_V1.0_REV3_0/smic28hkcPluslg_0918_1P8M_6Ic_2TMc_ALPA2_oa_cds_2018_12_05_v1.0_rev3_0/smic28hkmg/../models/spectre
  C0: temperature=25; vdc={From/To}Auto:0.9:17:0.388{From/To}; l0028hkcplus_io18_v1p0_rev3_spe.lib[mos_mc, mom_mc, var_mc, bjt_mc, ldmos_mc]
Monte Carlo Sampling options: mcmethod=all, mcnumpoints=200
