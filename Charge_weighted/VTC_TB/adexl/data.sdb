ADE simulation setup
Run mode: Single Run, Sweeps and Corners
Tests:
  Charge_weighted:VTC_TB:1: Charge_weighted/VTC_TB/schematic, simulator spectre
    Outputs: /I11/net037; /VTCO; /I11/net028; /I11/net049
Global variables:
  Vdc = {From/To}LinearStepCount:0:9:0.512{From/To}
  num_cap = {From/To}Linear:1:1:16{From/To}
Corners (all switched off):
  model folders: /netstorage/soft2/technology/SMIC28HKCP/pdk/SPDK28HKCPlusLG_0918_OA_CDS_V1.0_REV3_0/smic28hkcPluslg_0918_1P8M_6Ic_2TMc_ALPA2_oa_cds_2018_12_05_v1.0_rev3_0/smic28hkmg/../models/spectre
  MC_0_0 (off): Vdc=388e-3 420e-3 452e-3 484e-3 516e-3 548e-3 580e-3 612e-3 644e-3 676e-3 708e-3 740e-3 772e-3 804e-3 836e-3 868e-3 900e-3; l0028hkcplus_io18_v1p0_rev3_spe.lib[mos_mc, bjt_mc, dio_tt, res_mc, var_mc, mom_mc, ldmos_mc, esd_tt, esd_dio_tt]
  MC_N: Vdc={From/To}LinearStepCount:0:17:0.512{From/To}; l0028hkcplus_io18_v1p0_rev3_spe.lib[mos_mc, bjt_mc, dio_tt, res_mc, var_mc, mom_mc, ldmos_mc, esd_tt, esd_dio_tt]
