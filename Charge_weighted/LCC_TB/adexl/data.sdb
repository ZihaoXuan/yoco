ADE simulation setup
Run mode: Single Run, Sweeps and Corners
Tests:
  Charge_weighted:LCC_TB:1: Charge_weighted/LCC_TB/schematic, simulator spectre
