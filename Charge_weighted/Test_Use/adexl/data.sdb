ADE simulation setup
Run mode: Monte Carlo Sampling
Tests:
  Charge_weighted:Test_Use:1: Charge_weighted/Test_Use/schematic, simulator spectre
    Outputs: /net095; /VTCO; /I58/net088; /I58/net034
Global variables (all switched off):
  Vdc = {From/To}Linear:0:0.032:0.512{From/To}
Corners:
  model folders: /netstorage/soft2/technology/SMIC28HKCP/pdk/SPDK28HKCPlusLG_0918_OA_CDS_V1.0_REV3_0/smic28hkcPluslg_0918_1P8M_6Ic_2TMc_ALPA2_oa_cds_2018_12_05_v1.0_rev3_0/smic28hkmg/../models/spectre
  MC: Vdc=0 0.1 0.2 0.3 0.4 0.5; l0028hkcplus_io18_v1p0_rev3_spe.lib[mos_mc, bjt_mc, dio_tt, res_mc, var_mc, mom_mc, ldmos_mc, esd_tt, esd_dio_tt]
Monte Carlo Sampling options: mcmethod=all, mcnumpoints=200
