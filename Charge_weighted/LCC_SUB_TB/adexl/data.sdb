ADE simulation setup
Run mode: Single Run, Sweeps and Corners
Tests:
  Charge_weighted:LCC_SUB_TB:1: Charge_weighted/LCC_SUB_TB/schematic, simulator spectre
    Outputs: /I14/I0<7>/net7; /I14/I4<0>/net7
Global variables:
  a = {Inclusion List}0 0.9{Inclusion List}
  b = {Inclusion List}0 0.9{Inclusion List}
  c = {Inclusion List}0 0.9{Inclusion List}
  d = {Inclusion List}0 0.9{Inclusion List}
