ADE simulation setup
Run mode: Single Run, Sweeps and Corners
Tests:
  Charge_weighted:LCC_SUB256_TB:1 (off): Charge_weighted/LCC_SUB256_TB/schematic, simulator spectre
  Charge_weighted:LCC_Simple:1: Charge_weighted/LCC_Simple/schematic, simulator spectre
Global variables:
  a = {Inclusion List}0 0.9{Inclusion List} (off)
  b = {Inclusion List}0 0.9{Inclusion List} (off)
  c = {Inclusion List}0 0.9{Inclusion List} (off)
  d = {Inclusion List}0 0.9{Inclusion List} (off)
  e = {Inclusion List}0 0.9{Inclusion List} (off)
  f = {Inclusion List}0 0.9{Inclusion List} (off)
  g = {Inclusion List}0 0.9{Inclusion List} (off)
  h = {Inclusion List}0 0.9{Inclusion List} (off)
  IN = {From/To}Auto:0:256:0.877{From/To}
Corners (all switched off):
  model folders: /netstorage/soft2/technology/SMIC28HKCP/pdk/SPDK28HKCPlusLG_0918_OA_CDS_V1.0_REV3_0/smic28hkcPluslg_0918_1P8M_6Ic_2TMc_ALPA2_oa_cds_2018_12_05_v1.0_rev3_0/smic28hkmg/../models/spectre
  C1: temperature=25; a=0.9; b=0; c=0; d=0; IN=0.9; e=0; f=0; g=0; h=0; l0028hkcplus_io18_v1p0_rev3_spe.lib[tt, bjt_mc, dio_tt, res_mc, var_mc, mom_mc, ldmos_mc, esd_tt, esd_dio_tt]
